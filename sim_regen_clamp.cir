* Regen clamp (rev E): 36 V PSU behind the ideal diode, 15 A regen pulse into the bus for 40 ms
.model DIDEAL D(Is=1e-12 N=0.05 Rs=0.005)
.model DSS D(Is=1e-6 N=1.5 Rs=0.05 Cjo=100p)
.model D4148 D(Is=2.5n N=1.75 Rs=0.6 Cjo=2p)
.model QN NPN(Is=1e-14 Bf=150 Vaf=100 Cje=8p Cjc=4p Tf=0.3n)
.model QP PNP(Is=1e-14 Bf=150 Vaf=100 Cje=10p Cjc=5p Tf=0.4n)
.model SWI SW(Vt=0.5 Vh=0.1 Ron=2m Roff=1meg)
.model NFET VDMOS(nchan Vto=3 Kp=60 Rd=2m Rs=1m Cgdmax=1.5n Cgdmin=60p Cgs=6n Cjo=1n Rb=5m)
VPSU vin 0 36
* ideal diode Q1||Q7 (behavioural LM74800): DGATE = A + 11 V while forward, pulled to A about 2.6 us after reverse (TI: 0.5 us typ, so this is pessimistic)
SID vin vout dg_on 0 SWI
DBODY vin vout DSS
BDG dgctl 0 V = V(vin)-V(vout) > -0.0045 ? 1 : 0
RDGF dgctl dg_on 2.8k
CDGF dg_on 0 1n
BDGATE dgate 0 V = V(vin) + 11*V(dg_on)
Cbulk vout 0 1880u IC=35.9
Cmotor vout 0 600u IC=35.9
* regen: motors push 15 A back onto the bus from 10 ms to 50 ms
IREGEN 0 vout PWL(0 0 10m 0 10.1m 15 50m 15 50.1m 0)
* 11.6 V rail (ideal, the CJ431/BCP56 stage is checked separately)
VREG vreg 0 11.6
* sense network
R10 vout sp 100k
R11 sp 0 20k
R12 sp 0 220k
R13 vg sp 510k
R14 vin sn 100k
R15 sn 0 20k
R16 trim sn 150k
VTRIM trimsrc 0 6.2
RTRIM trimsrc trim 4k
* LM393 A: open collector, 300 ns response
BCMPA cmpctl 0 V = V(sp) > V(sn) ? 0 : 1
RCF cmpctl cmpd 1k
CCF cmpd 0 300p
SOA cmpout 0 cmpd 0 OCSW
.model OCSW SW(Vt=0.5 Ron=60 Roff=100meg)
R17 vreg pu 4.7k
RTH pu cmpout 0.01
R27 cmpout 0 100k
* U4 UCC27517 gate driver, non-inverting (IN- grounded), supplied from VREG. Behavioural model from the TI datasheet:
* input turns on above 2.2 V and off below 1.2 V (typ), about 5 ohm pull-up and 0.5 ohm pull-down, 230k input pull-down.
* The 13 ns delay is left out (far below the 1 us step). C18 = 1 nF filters CMP_OUT.
.model U4HI SW(Vt=1.7 Vh=0.5 Ron=5 Roff=100meg)
.model U4LO SW(Vt=1.7 Vh=0.5 Ron=0.5 Roff=100meg)
BU4N u4n 0 V = 3.4 - V(cmpout)
SU4H vreg vg cmpout 0 U4HI
SU4L vg 0 u4n 0 U4LO
RU4IN cmpout 0 230k
C18 cmpout 0 1n
R18 vg gate 10
R28 vg gate2 10
R29 gate2 0 10k
M9 drn gate2 0 0 NFET
R19 gate 0 10k
M3 drn gate 0 0 NFET
* brake resistor 2R with 1 uH wire-wound inductance, SS210 freewheel
RBR vout brl 2
LBR brl drn 1u
D4 drn vout DSS
* brake interlock (rev C): Q10 senses DGATE above VIN, Q11 holds CMP_OUT low while the ideal diode conducts
R34 dgate ilke 47k
R41 vin ilkbase 10k
Q10 ilkb ilkbase ilke QP
R35 ilkb 0 100k
Q11 cmpout ilkb 0 QN
* thermal-loop-open indicator (rev D): Q12 (S8550) conducts only when J11 is open; R37 = 1M keeps CMP_OUT low.
* To test it, change RTH to 1e12 (J11 open): the brake stays off and D9 carries about 0.9 mA.
.model DLEDY D(Is=1e-18 N=2 Rs=10)
Q12 thc thb pu QP
R37 cmpout thb 1meg
R38 thc ledt 2.2k
D9 ledt 0 DLEDY
* LED stretcher + LM393 B
D5 vg strd D4148
R20 strd str 100
C12 str 0 100n
R21 str 0 2meg
R22 vreg lref 47k
R23 lref 0 10k
BCMPB ledon 0 V = V(str) > V(lref) ? 1 : 0
.tran 1u 400m 0 1u uic
.control
run
let vrise = v(vout) - v(vin)
meas tran rise_max MAX vrise from=10m to=50m
meas tran rise_min MIN vrise from=20m to=50m
meas tran ipsu_rev MAX i(VPSU) from=10m to=50m
let ibr = (v(vout)-v(brl))/2
meas tran ibr_max MAX ibr
meas tran ibr_avg AVG ibr from=20m to=50m
meas tran gate_max MAX v(gate)
meas tran led_last WHEN v(ledon)=0.5 FALL=LAST
meas tran rise_end FIND vrise AT=60m
wrdata clamp60.dat v(vout) v(vin) v(gate) ibr v(ledon) v(str)
.endc
.end
