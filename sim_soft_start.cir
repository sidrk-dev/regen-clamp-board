* Hot plug and soft start, rev F: the supply lead is plugged in at t = 0 with SW1 off (everything discharged),
* then SW1 closes at 20 ms and Q2||Q8 ramp the output from 0 V
* LM74800 HGATE is modelled from its datasheet: a 55 uA source (39 min, 75 max) that stops when HGATE reaches
* OUT + 11.1 V (10 to 14.5 V), with R5 = 1k and the 400 nF ramp capacitor (C4, C5, C13, C14) to ground and D11 across
* gate-source. Q1||Q7 are on (the ideal diode conducts forward). The MOSFET model is the datasheet fit used in
* sim_post_layout.cir; the two soft-start MOSFETs are given thresholds 0.4 V apart to show unequal sharing.
* Load: the 1880 uF on the board, 600 uF of motor capacitance behind 1 m of lead, and RLOAD for electronics that
* draw current during the ramp (1e6 = none).
.param VS=36 IHG=55u RLOAD=1e6
.model NFETA VDMOS(nchan Vto=3.0 Kp=120 Rd=1.6m Rs=1m Rg=2 Cgdmax=2.5n Cgdmin=33p Cgs=6.7n Cjo=7.3n M=0.5 Vj=0.8 Rb=4m Is=1e-10 N=1.1)
.model NFETB VDMOS(nchan Vto=3.4 Kp=120 Rd=1.6m Rs=1m Rg=2 Cgdmax=2.5n Cgdmin=33p Cgs=6.7n Cjo=7.3n M=0.5 Vj=0.8 Rb=4m Is=1e-10 N=1.1)
.model DZ12 D(Is=1e-12 N=1 BV=12 IBV=5m Rs=5)
VPSU psu 0 {VS}
RPSU psu p1 20m
LCAB p1 vin 1u
C17 vin c17a 470u IC=0
C1 vin 0 1u IC=0
RC17 c17a 0 80m
RID vin mid 2.6m
* HGATE: current source gated by SW1 (EN), limited to OUT + 11.1 V. While off, HGATE is held to OUT (20 ohm here;
* the datasheet gives a 260 mA sink).
VEN en 0 PWL(0 0 20m 0 20.001m 1)
BHG 0 hgate I = V(en) > 0.5 ? {IHG} * min(1, max(0, (V(vout) + 11.1 - V(hgate)) / 0.2)) : 0
RHGOFF hgate hgoff 20
SOFF hgoff vout enb 0 SWOFF
BENB enb 0 V = 1 - V(en)
.model SWOFF SW(Vt=0.5 Ron=1 Roff=1g)
R5 hgate cdvdt 1k
CDV cdvdt 0 400n IC=0
D11 vout hgate DZ12
R32 hgate g2 10
R33 hgate g8 10
VQ2 mid d2 0
M2 d2 g2 vout vout NFETA
VQ8 mid d8 0
M8 d8 g8 vout vout NFETB
CBULK vout cb1 1880u IC=0
RCB cb1 0 20m
RMC vout m2 16m
LMC m2 vmot 0.7u
CMOT vmot cm1 600u IC=0
RCM cm1 0 30m
RL vmot 0 {RLOAD}
.option method=gear reltol=1e-3
.tran 1u 1.6 0 50u uic
.control
set noaskquit
foreach c 1 2 3 4
  if $c = 2
    alterparam VS=48
    reset
  end
  if $c = 3
    alterparam IHG=75u
    reset
  end
  if $c = 4
    alterparam RLOAD=96
    reset
  end
  run
  echo corner $c
  let p2 = (v(mid)-v(vout))*i(VQ2)
  let p8 = (v(mid)-v(vout))*i(VQ8)
  let iin = i(VQ2)+i(VQ8)
  let vgs = v(hgate)-v(vout)
  let j1_current = -i(VPSU)
  let output_fraction = v(vout)/v(psu)
  * hot plug, SW1 off: input connector current includes C17 before the switch
  meas tran plug_j1_max MAX j1_current from=0 to=20m
  meas tran plug_vin_max MAX v(vin) from=0 to=20m
  meas tran plug_iq_max MAX iin from=0 to=20m
  meas tran plug_vgs_max MAX vgs from=0 to=20m
  meas tran plug_vout_max MAX v(vout) from=0 to=20m
  * soft start
  meas tran inrush_max MAX iin from=20m to=1.6
  meas tran i_q2_max MAX i(VQ2) from=20m to=1.6
  meas tran i_q8_max MAX i(VQ8) from=20m to=1.6
  meas tran p_q2_max MAX p2 from=20m to=1.6
  meas tran e_q2 INTEG p2 from=20m to=1.6
  meas tran e_q8 INTEG p8 from=20m to=1.6
  meas tran t_10 WHEN output_fraction=0.1 RISE=1
  meas tran t_90 WHEN output_fraction=0.9 RISE=1
  meas tran vout_end FIND v(vout) AT=1.6
  meas tran vgs_end FIND vgs AT=1.6
  meas tran vgs_max MAX vgs
end
.endc
.end
